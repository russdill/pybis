[IBIS ver]   3.2
[File name]   sample1.ibs
[File Rev]   0
[Date]   10/23/2001
[Source]   Company_ABC, Adapted From Real IBIS Model
[Copyright]   Public Sample
|   Component WXY123
[Component]   WXY123
[Manufacturer]   Company_ABC
[Package]
| variable   typ   min   max
R_pkg   0.0m   0.0m   0.0m
L_pkg   3.0nH   2.0nH   4.0nH
C_pkg   0.5pF   0.3pF   0.8pf
[Pin]  signal_name   model_name   R_pin   L_pin   C_pin
 A10   cs1   BT2Z50CX   32m   3.44nH   0.46pF
 A11   wrn   BT2Z50CX   31m   3.39nH   0.46pF
 A12   a[0]   BT2Z50CX_PU50K   32m   3.45nH   0.46pF
 A13   a[4]   BT2Z50CX_PU50K   33m   3.54nH   0.47pF
 A14   a[7]   BT2Z50CX_PU50K   35m   3.69nH   0.48pF
 A15   a[10]   BT2Z50CX_PU50K   37m   3.89nH   0.49pF
 A16   a[14]   BT2Z50CX_PU50K   40m   4.09nH   0.51pF
 A17   a[17]   BT2Z50CX_PU50K   43m   4.35nH   0.53pF
 A18   a[18]   BT2Z50CX_PU50K   48m   4.71nH   0.56pF
 A19   a[23]   BT2Z50CX_PU50K   50m   4.91nH   0.57pF
  A2   d[0]   BT2Z50CX_PU50K   51m   5.01nH   0.58pF
 A20   irdarx0   BPIST02F_PU50K   56m   5.37nH   0.6pF
  A3   d[5]   BT2Z50CX_PU50K   49m   4.81nH   0.56pF
  A4   d[8]   BT2Z50CX_PU50K   45m   4.52nH   0.54pF
  A5   d[12]   BT2Z50CX_PU50K   42m   4.29nH   0.53pF
  A6   d[15]   BT2Z50CX_PU50K   39m   4.04nH   0.51pF
  A7   sdldqm   BT2Z50CX   36m   3.78nH   0.49pF
  A8   sdcasn   BT2Z50CX   34m   3.6nH   0.47pF
  A9   exwait   BT2Z50CX   33m   3.5nH   0.46pF
  B1   dsp_d[0]   BT2Z50CX_PU50K   50m   4.91nH   0.57pF
 B10   cs2   BT2Z50CX   24m   2.77nH   0.41pF
 B11   flash_cs   BT2Z50CX   23m   2.75nH   0.41pF
 B12   a[1]   BT2Z50CX_PU50K   24m   2.79nH   0.41pF
 B13   a[5]   BT2Z50CX_PU50K   25m   2.9nH   0.42pF
 B14   a[8]   BT2Z50CX_PU50K   27m   3.07nH   0.43pF
 B15   a[11]   BT2Z50CX_PU50K   30m   3.29nH   0.45pF
 B16   a[15]   BT2Z50CX_PU50K   33m   3.51nH   0.47pF
 B17   a[21]   BT2Z50CX_PU50K   35m   3.67nH   0.48pF
 B18   a[22]   BT2Z50CX_PU50K   39m   4.03nH   0.5pF
 B19   irdatx0   BPOZ4F   45m   4.51nH   0.54pF
  B2   d[1]   BT2Z50CX_PU50K   47m   4.63nH   0.55pF
 B20   tx1   BPOZ4F   52m   5.06nH   0.58pF
  B3   d[2]   BT2Z50CX_PU50K   41m   4.19nH   0.52pF
  B4   d[6]   BT2Z50CX_PU50K   38m   3.94nH   0.5pF
  B5   d[9]   BT2Z50CX_PU50K   34m   3.65nH   0.48pF
  B6   d[13]   BT2Z50CX_PU50K   32m   3.42nH   0.46pF
  B7   sdudqm   BT2Z50CX   29m   3.17nH   0.44pF
  B8   sdwen   BT2Z50CX   26m   2.97nH   0.43pF
  B9   exint1   BPIST02F   25m   2.85nH   0.42pF
  C1   dsp_d[5]   BT2Z50CX_PU50K   48m   4.71nH   0.56pF
 C10   cs3   BT2Z50CX   15m   2.11nH   0.36pF
 C11   rdn   BT2Z50CX   15m   2.09nH   0.36pF
 C12   a[2]   BT2Z50CX_PU50K   16m   2.14nH   0.36pF
 C13   a[6]   BT2Z50CX_PU50K   17m   2.26nH   0.37pF
 C14   a[9]   BT2Z50CX_PU50K   20m   2.47nH   0.39pF
 C15   a[13]   BT2Z50CX_PU50K   22m   2.68nH   0.4pF
 C16   a[16]   BT2Z50CX_PU50K   26m   2.96nH   0.42pF
 C17   a[20]   BT2Z50CX_PU50K   29m   3.21nH   0.44pF
 C18   rx1   BPIST02F_PU50K   35m   3.65nH   0.48pF
 C19   VSS   GND   41m   4.19nH   0.52pF
  C2   dsp_d[1]   BT2Z50CX_PU50K   39m   4.03nH   0.5pF
 C20   VDD   POWER   49m   4.81nH   0.56pF
  C3   vref   BIP00F   34m   3.59nH   0.47pF
  C4   d[3]   BT2Z50CX_PU50K   31m   3.33nH   0.45pF
  C5   d[7]   BT2Z50CX_PU50K   27m   3.07nH   0.43pF
  C6   d[10]   BT2Z50CX_PU50K   24m   2.77nH   0.41pF
  C7   d[14]   BT2Z50CX_PU50K   21m   2.55nH   0.39pF
  C8   sdrck   BT2Z50CX_PU50K   19m   2.36nH   0.38pF
  C9   exint2   BPIST02F   17m   2.21nH   0.37pF
  D1   dsp_d[6]   BT2Z50CX_PU50K   43m   4.35nH   0.53pF
 D10   be1n   BT2Z50CX   7m   1.46nH   0.31pF
 D12   a[3]   BT2Z50CX_PU50K   8m   1.49nH   0.32pF
 D14   a[12]   BT2Z50CX_PU50K   12m   1.81nH   0.34pF
 D16   a[19]   BT2Z50CX_PU50K   18m   2.35nH   0.38pF
 D18   dmns   BUSB6AU   31m   3.33nH   0.45pF
 D19   pwrfltn   BPIN15F_PU50K   38m   3.94nH   0.5pF
  D2   dsp_d[2]   BT2Z50CX_PU50K   35m   3.67nH   0.48pF
 D20   ppi[0]   BPS2P4F_PU50K   45m   4.52nH   0.54pF
  D3   dsp_d[3]   BT2Z50CX_PU50K   29m   3.21nH   0.44pF
  D5   d[4]   BT2Z50CX_PU50K   20m   2.48nH   0.39pF
  D7   d[11]   BT2Z50CX_PU50K   13m   1.91nH   0.35pF
  D9   sdrasn   BT2Z50CX   9m   1.59nH   0.32pF
  E1   dsp_d[9]   BT2Z50CX_PU50K   40m   4.09nH   0.51pF
 E17   dpls   BUSB6AU   20m   2.48nH   0.39pF
 E18   prtpwr   BPS2P4F_PU50K   27m   3.07nH   0.43pF
 E19   ppi[1]   BPS2P4F_PU50K   34m   3.65nH   0.48pF
  E2   dsp_d[8]   BT2Z50CX_PU50K   33m   3.51nH   0.47pF
 E20   ppi[4]   BPS2P4F_PU50K   42m   4.29nH   0.53pF
  E3   dsp_d[7]   BT2Z50CX_PU50K   26m   2.96nH   0.42pF
  E4   dsp_d[4]   BT2Z50CX_PU50K   18m   2.35nH   0.38pF
  F1  dsp_d[13]   BT2Z50CX_PU50K   37m   3.89nH   0.49pF
 F18   ppi[2]   BPS2P4F_PU50K   24m   2.77nH   0.41pF
 F19   ppi[5]   BPS2P4F_PU50K   32m   3.42nH   0.46pF
  F2  dsp_d[12]   BT2Z50CX_PU50K   30m   3.29nH   0.45pF
 F20   ppi[7]   BPS2P4F_PU50K   39m   4.04nH   0.51pF
  F3  dsp_d[10]   BT2Z50CX_PU50K   22m   2.68nH   0.4pF
  G1   dsp_rwn   BT2Z50CX   35m   3.69nH   0.48pF
 G17   ppi[3]   BPS2P4F_PU50K   13m   1.91nH   0.35pF
 G18   ppi[6]   BPS2P4F_PU50K   21m   2.55nH   0.39pF
 G19   ppi[8]   BPS2P4F_PU50K   29m   3.17nH   0.44pF
  G2  dsp_d[15]   BT2Z50CX_PU50K   27m   3.07nH   0.43pF
 G20   ppi[9]   BPS2P4F_PU50K   36m   3.78nH   0.49pF
  G3  dsp_d[14]   BT2Z50CX_PU50K   20m   2.47nH   0.39pF
  G4  dsp_d[11]   BT2Z50CX_PU50K   12m   1.81nH   0.34pF
  H1   dsp_a[0]   BT2Z50CX_PU50K   33m   3.54nH   0.47pF
 H18   ppi[10]   BPS2P4F_PU50K   19m   2.36nH   0.38pF
 H19   ppi[11]   BPS2P4F_PU50K   26m   2.97nH   0.43pF
  H2   dsp_icsn   BT2Z50CX   25m   2.9nH   0.42pF
 H20   ppi[12]   BPS2P4F_PU50K   34m   3.6nH   0.47pF
  H3   dsp_mcsn   BT2Z50CX   17m   2.26nH   0.37pF
  J1   dsp_a[4]   BT2Z50CX_PU50K   32m   3.45nH   0.46pF
 J17   ppi[13]   BPS2P4F_PU50K   9m   1.59nH   0.32pF
 J18   ppi[14]   BPS2P4F_PU50K   17m   2.21nH   0.37pF
 J19   ppi[15]   BPS2P4F_PU50K   25m   2.85nH   0.42pF
  J2   dsp_a[3]   BT2Z50CX_PU50K   24m   2.79nH   0.41pF
 J20 ls10_ok[1]   BPS2P10F_PU50K   33m   3.5nH   0.46pF
  J3   dsp_a[2]   BT2Z50CX_PU50K   16m   2.14nH   0.36pF
  J4   dsp_a[1]   BT2Z50CX_PU50K   8m   1.49nH   0.32pF
  K1   dsp_a[7]   BT2Z50CX_PU50K   31m   3.39nH   0.46pF
 K17 ls10_ok[0]   BPS2P10F_PU50K   7m   1.46nH   0.31pF
 K18 ls100_ok[1]   BPS2P10F_PU50K   15m   2.11nH   0.36pF
 K19 ls100_ok[0]   BPS2P10F_PU50K   24m   2.77nH   0.41pF
  K2   dsp_a[5]   BT2Z50CX_PU50K   23m   2.75nH   0.41pF
 K20   NC   NC   32m   3.44nH   0.46pF
  K3   dsp_a[6]   BT2Z50CX_PU50K   15m   2.09nH   0.36pF
  L1   dsp_a[8]   BT2Z50CX_PU50K   32m   3.44nH   0.46pF
 L18   NC   NC   15m   2.09nH   0.36pF
 L19   NC   NC   23m   2.75nH   0.41pF
  L2   dsp_a[9]   BT2Z50CX_PU50K   24m   2.77nH   0.41pF
 L20   NC   NC   31m   3.39nH   0.46pF
  L3  dsp_a[10]   BT2Z50CX_PU50K   15m   2.11nH   0.36pF
  L4  dsp_intn0   BT2Z50CX   7m   1.46nH   0.31pF
  M1   tstclk   BPOZ2F   33m   3.5nH   0.46pF
 M17   NC   NC   8m   1.49nH   0.32pF
 M18   NC   NC   16m   2.14nH   0.36pF
 M19   NC   NC   24m   2.79nH   0.41pF
  M2   clkref   BPOZ2F   25m   2.85nH   0.42pF
 M20   NC   NC   32m   3.45nH   0.46pF
  M3   NC   NC   17m   2.21nH   0.37pF
  M4   NC   NC   9m   1.59nH   0.32pF
  N1   resetn   BPIST02F_PU50K   34m   3.6nH   0.47pF
 N18   NC   NC   17m   2.26nH   0.37pF
 N19   NC   NC   25m   2.9nH   0.42pF
  N2   rston   BPOZ4F   26m   2.97nH   0.43pF
 N20   NC   NC   33m   3.54nH   0.47pF
  N3   jtdo   BPOZ4F   19m   2.36nH   0.38pF
  P1   jtrstn   BPIST02F_PU50K   36m   3.78nH   0.49pF
 P17   NC   NC   12m   1.81nH   0.34pF
 P18   NC   NC   20m   2.47nH   0.39pF
 P19   NC   NC   27m   3.07nH   0.43pF
  P2   jtms   BPIST02F_PU50K   29m   3.17nH   0.44pF
 P20   NC   NC   35m   3.69nH   0.48pF
  P3   jtck   BPIST02F_PU50K   21m   2.55nH   0.39pF
  P4   NC   NC   13m   1.91nH   0.35pF
  R1   jtdi   BPIST02F_PU50K   39m   4.04nH   0.51pF
 R18   NC   NC   22m   2.68nH   0.4pF
 R19   NC   NC   30m   3.29nH   0.45pF
  R2   NC   NC   32m   3.42nH   0.46pF
 R20   NC   NC   37m   3.89nH   0.49pF
  R3   NC   NC   24m   2.77nH   0.41pF
  T1   NC   NC   42m   4.29nH   0.53pF
 T17   NC   NC   18m   2.35nH   0.38pF
 T18   NC   NC   26m   2.96nH   0.42pF
 T19   NC   NC   33m   3.51nH   0.47pF
  T2   t_ack   BPOZ4F   34m   3.65nH   0.48pF
 T20   NC   NC   40m   4.09nH   0.51pF
  T3   t_reqa   BPIN15F_PU50K   27m   3.07nH   0.43pF
  T4   xtal0   NC   20m   2.48nH   0.39pF
  U1   t_reqb   BPIN15F_PU50K   45m   4.52nH   0.54pF
 U11   NC   NC   7m   1.46nH   0.31pF
 U12 testpt[17]   BPS2P4F_PU50K   9m   1.59nH   0.32pF
 U14  testpt[7]   BPS2P4F_PU50K   13m   1.91nH   0.35pF
 U16  testpt[0]   BPS2P4F_PU50K   20m   2.48nH   0.39pF
 U18   NC   NC   29m   3.21nH   0.44pF
 U19   NC   NC   35m   3.67nH   0.48pF
  U2   NC   NC   38m   3.94nH   0.5pF
 U20   NC   NC   43m   4.35nH   0.53pF
  U3   NC   NC   31m   3.33nH   0.45pF
  U5   k_row[2]   BPS2P10F_PU50K   18m   2.35nH   0.38pF
  U7   k_col[3]   BPS2P4F_PD50K   12m   1.81nH   0.34pF
  U9   tmode[1]   BPIN15F_PU50K   8m   1.49nH   0.32pF
  V1   xtal1   NC   49m   4.81nH   0.56pF
 V10   NC   NC   15m   2.09nH   0.36pF
 V11   NC   NC   15m   2.11nH   0.36pF
 V12 testpt[18]   BPS2P4F_PU50K   17m   2.21nH   0.37pF
 V13 testpt[14]   BPS2P4F_PU50K   19m   2.36nH   0.38pF
 V14 testpt[10]   BPS2P4F_PU50K   21m   2.55nH   0.39pF
 V15  testpt[6]   BPS2P4F_PU50K   24m   2.77nH   0.41pF
 V16  testpt[3]   BPS2P4F_PU50K   27m   3.07nH   0.43pF
 V17 omuxsel[0]   BPIN15F_PU50K   31m   3.33nH   0.45pF
 V18   jmode   BPS2P4F_PU50K   35m   3.65nH   0.48pF
 V19   NC   NC   39m   4.03nH   0.5pF
  V2   sck   BPS2P4F_PU50K   41m   4.19nH   0.52pF
 V20   NC   NC   48m   4.71nH   0.56pF
  V3   mdisdo   BPS2P4F_PU50K   35m   3.65nH   0.48pF
  V4   k_row[3]   BPS2P10F_PU50K   29m   3.21nH   0.44pF
  V5   k_col[7]   BPS2P4F_PD50K   26m   2.96nH   0.42pF
  V6   k_col[4]   BPS2P4F_PD50K   22m   2.68nH   0.4pF
  V7   k_col[0]   BPS2P4F_PU50K   20m   2.47nH   0.39pF
  V8   spkrled   BPS2P10F_PU50K   17m   2.26nH   0.37pF
  V9   tmode[2]   BPIN15F_PU50K   16m   2.14nH   0.36pF
  W1   mdosdi   BPS2P4F_PU50K   52m   5.06nH   0.58pF
 W10   sc_enan   BPS2P4F_PU50K   23m   2.75nH   0.41pF
 W11   NC   NC   24m   2.77nH   0.41pF
 W12 testpt[19]   BPS2P4F_PU50K   25m   2.85nH   0.42pF
 W13 testpt[15]   BPS2P4F_PU50K   26m   2.97nH   0.43pF
 W14 testpt[12]   BPS2P4F_PU50K   29m   3.17nH   0.44pF
 W15  testpt[9]   BPS2P4F_PU50K   32m   3.42nH   0.46pF
 W16  testpt[5]   BPS2P4F_PU50K   34m   3.65nH   0.48pF
 W17  testpt[2]   BPS2P4F_PU50K   38m   3.94nH   0.5pF
 W18 omuxsel[1]   BPIN15F_PU50K   41m   4.19nH   0.52pF
 W19   xs[0]   BPS2P10F_PU50K   45m   4.51nH   0.54pF
  W2   ssn   BPS2P4F_PU50K   45m   4.51nH   0.54pF
 W20   NC   NC   50m   4.91nH   0.57pF
  W3   k_row[6]   BPS2P10F_PU50K   39m   3.98nH   0.5pF
  W4   k_row[4]   BPS2P10F_PU50K   35m   3.67nH   0.48pF
  W5   k_col[6]   BPS2P4F_PD50K   33m   3.51nH   0.47pF
  W6   k_col[2]   BPS2P4F_PD50K   30m   3.29nH   0.45pF
  W7   lcntrl   BPS2P10F_PU50K   27m   3.07nH   0.43pF
  W8   swhook   BPS2P10F_PU50K   25m   2.9nH   0.42pF
  W9   tmode[3]   BPIN15F_PU50K   24m   2.79nH   0.41pF
  Y1   usbaltck   BPS2P4F_PU50K   56m   5.37nH   0.6pF
 Y10   NC   NC   31m   3.39nH   0.46pF
 Y11   NC   NC   32m   3.44nH   0.46pF
 Y12   NC   NC   33m   3.5nH   0.46pF
 Y13 testpt[16]   BPS2P4F_PU50K   34m   3.6nH   0.47pF
 Y14 testpt[13]   BPS2P4F_PU50K   36m   3.78nH   0.49pF
 Y15 testpt[11]   BPS2P4F_PU50K   39m   4.04nH   0.51pF
 Y16  testpt[8]   BPS2P4F_PU50K   42m   4.29nH   0.53pF
 Y17  testpt[4]   BPS2P4F_PU50K   45m   4.52nH   0.54pF
 Y18  testpt[1]   BPS2P4F_PU50K   49m   4.81nH   0.56pF
 Y19 omuxsel[2]   BPIN15F_PU50K   52m   5.06nH   0.58pF
  Y2   k_row[5]   BPS2P10F_PU50K   51m   4.96nH   0.57pF
 Y20   xs[1]   BPS2P10F_PU50K   56m   5.37nH   0.6pF
  Y3   k_row[1]   BPS2P10F_PU50K   48m   4.71nH   0.56pF
  Y4   k_row[0]   BPS2P10F_PU50K   43m   4.35nH   0.53pF
  Y5   k_col[5]   BPS2P4F_PD50K   40m   4.09nH   0.51pF
  Y6   k_col[1]   BPS2P4F_PD50K   37m   3.89nH   0.49pF
  Y7   msgled   BPS2P10F_PU50K   35m   3.69nH   0.48pF
  Y8   tmode[0]   BPIN15F_PU50K   33m   3.54nH   0.47pF
  Y9   sc_moden   BPS2P4F_PU50K   32m   3.45nH   0.46pF
[Diff Pin]   inv_pin  vdiff  tdelay_typ tdelay_min tdelay_max
E17   D18   2.0   NA   NA   NA
[Model selector]   BUSB6AU
BUSB6AU_HIGH_SPEED   USB_HIGH_SPEED
BUSB6AU_LOW_SPEED   USB_LOW_SPEED
| Models and submodels in the file (14): BIP00F (Input), BIPIN15F (Input), BPIN15F_PU50K (Input), BPIST02F (Input), BPIST02F_PU50K (Input), BPOZ2F (3-state), BPOZ4F (3-state), BPS2P10F_PU50K (I/O), BPS2P4F_PD50K (I/O), BPS2P4F_PU50K (I/O), BT2Z50CX (I/O), BT2Z50CX_PU50K (I/O), BUSB6AU_HIGH_SPEED (I/O), BUSB6AU_LOW_SPEED (I/O)
